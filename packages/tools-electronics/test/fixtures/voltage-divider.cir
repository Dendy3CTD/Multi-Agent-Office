10 V voltage divider
V1 in 0 DC 10
R1 in out 10k
R2 out 0 10k
.op
.print op v(out)
.save all
.end
